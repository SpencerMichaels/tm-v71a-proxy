example proxy
* --- board (from KiCad netlist) ---
Rref_n__5V n__5V 0 1G
Rref_n_BODY_TXD n_BODY_TXD 0 1G
Rref_n_DBG_TX n_DBG_TX 0 1G
Rref_n_DBG_TX_MCU n_DBG_TX_MCU 0 1G
Rref_n_HEAD_RXD n_HEAD_RXD 0 1G
Rref_n_HEAD_TXD n_HEAD_TXD 0 1G
Rref_n_HEAD_TX_MCU n_HEAD_TX_MCU 0 1G
Rref_n_ILL_GND n_ILL_GND 0 1G
Rref_n_ILL_LED_A n_ILL_LED_A 0 1G
Rref_n_ILL_P n_ILL_P 0 1G
Rref_n_ILL_SENSE n_ILL_SENSE 0 1G
Rref_n_PB n_PB 0 1G
Rref_n_PB_FILT n_PB_FILT 0 1G
Rref_n_TAP_BODY n_TAP_BODY 0 1G
Rref_n_TAP_HEAD n_TAP_HEAD 0 1G
Rref_n_UPDI n_UPDI 0 1G
Rref_n_XTAL32K1 n_XTAL32K1 0 1G
Rref_n_XTAL32K2 n_XTAL32K2 0 1G
Rref_n_unconnected__U1_PA2_Pad24_ n_unconnected__U1_PA2_Pad24_ 0 1G
Rref_n_unconnected__U1_PA3_Pad25_ n_unconnected__U1_PA3_Pad25_ 0 1G
Rref_n_unconnected__U1_PA4_Pad26_ n_unconnected__U1_PA4_Pad26_ 0 1G
Rref_n_unconnected__U1_PA5_Pad27_ n_unconnected__U1_PA5_Pad27_ 0 1G
Rref_n_unconnected__U1_PA6_Pad28_ n_unconnected__U1_PA6_Pad28_ 0 1G
Rref_n_unconnected__U1_PA7_Pad1_ n_unconnected__U1_PA7_Pad1_ 0 1G
Rref_n_unconnected__U1_PC2_Pad4_ n_unconnected__U1_PC2_Pad4_ 0 1G
Rref_n_unconnected__U1_PC3_Pad5_ n_unconnected__U1_PC3_Pad5_ 0 1G
Rref_n_unconnected__U1_PD2_Pad8_ n_unconnected__U1_PD2_Pad8_ 0 1G
Rref_n_unconnected__U1_PD3_Pad9_ n_unconnected__U1_PD3_Pad9_ 0 1G
Rref_n_unconnected__U1_PD4_Pad10_ n_unconnected__U1_PD4_Pad10_ 0 1G
Rref_n_unconnected__U1_PD5_Pad11_ n_unconnected__U1_PD5_Pad11_ 0 1G
Rref_n_unconnected__U1_PD6_Pad12_ n_unconnected__U1_PD6_Pad12_ 0 1G
Rref_n_unconnected__U1_VREFA_PD7_Pad13_ n_unconnected__U1_VREFA_PD7_Pad13_ 0 1G
Rref_n_unconnected__U1___RESET__PF6_Pad18_ n_unconnected__U1___RESET__PF6_Pad18_ 0 1G
R2 n_HEAD_TX_MCU n_HEAD_RXD 470
R6 n_BODY_TXD n_TAP_BODY 10000
R7 n_HEAD_TXD n_TAP_HEAD 10000
R1 n_PB n_PB_FILT 150
C6 n_PB_FILT C6_esr 1e-05
RC6esr C6_esr 0 1.0
C5 n_PB_FILT 0 1e-07
C4 n__5V C4_esr 2.2e-05
RC4esr C4_esr 0 1.5
C1 n__5V 0 1e-07
C2 n__5V 0 1e-07
C3 n__5V 0 1e-07
C7 n_XTAL32K1 0 1.5e-11
C8 n_XTAL32K2 0 1.5e-11
R9 n_ILL_P n_ILL_LED_A 2200
R10 n_ILL_LED_A n_ILL_GND 680
R11 n__5V n_ILL_SENSE 10000
R13 n_DBG_TX_MCU n_DBG_TX 470
D1 n_ILL_GND n_ILL_LED_A DSIG
VU3s n_ILL_LED_A u3a 0
DU3 u3a n_ILL_GND DOPT
BU3f u3f 0 V=I(VU3s)
RU3f u3f u3g 1k
CU3f u3g 0 1e-08
BU3c n_ILL_SENSE 0 I=0.7*max(V(u3g),0)*tanh(max(V(n_ILL_SENSE,0),0)/0.15)
CU3ce n_ILL_SENSE 0 5p
BU2 u2x 0 V=min(5.0,max(V(n_PB_FILT)-0.25,0))
RU2o u2x u2o 0.45
VU2s u2o n__5V 0
FU2 n_PB_FILT 0 VU2s 1
IU2q n_PB_FILT 0 DC 0.1m
IU1 n__5V 0 DC 0.0044
DU1h3 n_TAP_HEAD n__5V DCLAMP
DU1l3 0 n_TAP_HEAD DCLAMP
CU1_3 n_TAP_HEAD 0 4p
DU1h23 n_TAP_BODY n__5V DCLAMP
DU1l23 0 n_TAP_BODY DCLAMP
CU1_23 n_TAP_BODY 0 4p
DU1h7 n_ILL_SENSE n__5V DCLAMP
DU1l7 0 n_ILL_SENSE DCLAMP
CU1_7 n_ILL_SENSE 0 4p
DU1h2 n_HEAD_TX_MCU n__5V DCLAMP
DU1l2 0 n_HEAD_TX_MCU DCLAMP
CU1_2 n_HEAD_TX_MCU 0 4p
DU1h22 n_DBG_TX_MCU n__5V DCLAMP
DU1l22 0 n_DBG_TX_MCU DCLAMP
CU1_22 n_DBG_TX_MCU 0 4p
BU1d2 u1d2 0 V=V(n__5V)*V(lv_tx)
RU1o2 u1d2 n_HEAD_TX_MCU 25.0
BU1d22 u1d22 0 V=V(n__5V)*V(lv_dbg)
RU1o22 u1d22 n_DBG_TX_MCU 25.0
* --- radio body / head / Toyota ILL environment ---
Vpb pbsrc 0 DC 10.0
Rpbsrc pbsrc n_PB 0.2
Ihead n_PB 0 DC 0.15
Vb5 vb5 0 DC 5.0
Vh5 vh5 0 DC 5.0
Vbtx btxd 0 PWL(0 5 2e-05 5 2.0000001e-05 5 2.002e-05 0 3.73611111e-05 0 3.73811111e-05 5 5.47222222e-05 5 5.47422222e-05 0 7.20833333e-05 0 7.21033333e-05 5 8.94444444e-05 5 8.94644444e-05 0 0.000106805556 0
+ 0.000106825556 5 0.000124166667 5 0.000124186667 0 0.000141527778 0 0.000141547778 5 0.000158888889 5 0.000158908889 0 0.00017625 0 0.00017627 5 0.000193611111 5 0.000193631111 0 0.000349861111 0
+ 0.000349881111 5 0.000367222222 5 0.000367242222 0 0.000384583333 0 0.000384603333 5 0.000540833333 5 0.000540853333 0 0.000558194444 0 0.000558214444 5 0.000592916667 5 0.000592936667 0
+ 0.000627638889 0 0.000627658889 5 0.000662361111 5 0.000662381111 0 0.000697083333 0 0.000697103333 5 0.000714444444 5 0.000714464444 0 0.000731805556 0 0.000731825556 5 0.000749166667 5
+ 0.000749186667 0 0.000766527778 0 0.000766547778 5 0.00080125 5 0.00080127 0 0.000870694444 0 0.000870714444 5 0.00113111111 5
+ )
Rbout btxd btxo 50.0
R956 btxo n_BODY_TXD 1k
Cbcab4 n_BODY_TXD 0 2.6e-10
Cbcab3 n_HEAD_TXD 0 2.6e-10
R953 n_HEAD_TXD brx 1k
Rbpu brx vb5 47k
Cbrx brx 0 10p
Chcab4 n_HEAD_RXD 0 2e-11
Chvar4 n_HEAD_RXD 0 5e-11
Rhpu n_HEAD_RXD vh5 47k
Chin n_HEAD_RXD 0 5p
Vhtx htxd 0 DC 5.0
Rhout htxd n_HEAD_TXD 750.0
Chcab3 n_HEAD_TXD 0 2e-11
Chvar3 n_HEAD_TXD 0 5e-11
Vlv_tx lv_tx 0 PWL(0 1 0.000193611111 1 0.000193611112 1 0.000193631111 0 0.000210972222 0 0.000210992222 1 0.000245694444 1 0.000245714444 0 0.000280416667 0 0.000280436667 1 0.000315138889 1 0.000315158889 0
+ 0.000349861111 0 0.000349881111 1 0.000367222222 1 0.000367242222 0 0.000419305556 0 0.000419325556 1 0.000436666667 1 0.000436686667 0 0.000454027778 0 0.000454047778 1 0.00048875 1 0.00048877 0
+ 0.000523472222 0 0.000523492222 1 0.000540833333 1 0.000540853333 0 0.000558194444 0 0.000558214444 1 0.000575555556 1 0.000575575556 0 0.000592916667 0 0.000592936667 1 0.000627638889 1
+ 0.000627658889 0 0.000697083333 0 0.000697103333 1 0.000714444444 1 0.000714464444 0 0.000731805556 0 0.000731825556 1 0.000749166667 1 0.000749186667 0 0.000766527778 0 0.000766547778 1
+ 0.000783888889 1 0.000783908889 0 0.00080125 0 0.00080127 1 0.000818611111 1 0.000818631111 0 0.000835972222 0 0.000835992222 1 0.000853333333 1 0.000853353333 0 0.000870694444 0 0.000870714444 1
+ 0.000888055556 1 0.000888075556 0 0.00104430556 0 0.00104432556 1 0.00113111111 1
+ )
Vlv_dbg lv_dbg 0 DC 1
Vill ills 0 DC 0.0
Rills ills n_ILL_P 0.5
Rgnd n_ILL_GND 0 0.05
Rlamp n_ILL_P 0 60

.model DSIG D(Is=2.52n N=1.752 Rs=0.568 Cjo=4p M=0.4 tt=20n Bv=100 Ibv=100u)
.model DCLAMP D(Is=1f N=1.0 Rs=50 Cjo=1p)
.model DOPT D(Is=1.6e-13 N=1.8 Rs=2 Bv=6 Ibv=10u Cjo=20p)
.model DBODY D(Is=1p N=1.3 Rs=.1)

.options method=gear reltol=1e-4 abstol=1e-11 vntol=1e-6 itl4=200
.end
